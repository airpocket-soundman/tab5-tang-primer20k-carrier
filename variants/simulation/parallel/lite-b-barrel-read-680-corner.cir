Tab5-Core parallel finite-edge distributed RLC sensitivity
.options reltol=1e-5 abstol=1e-12 method=trap
.param pi=3.14159265359
Rtab0 host n2 0.032
Ltab0 n2 n1 3.58639577403e-09
Ctab0 n1 0 4.96386958343e-13
Rtab1 n1 n4 0.032
Ltab1 n4 n3 3.58639577403e-09
Ctab1 n3 0 4.96386958343e-13
Rtab2 n3 n6 0.032
Ltab2 n6 n5 3.58639577403e-09
Ctab2 n5 0 4.96386958343e-13
Rtab3 n5 n8 0.032
Ltab3 n8 n7 3.58639577403e-09
Ctab3 n7 0 4.96386958343e-13
Rtab4 n7 n10 0.032
Ltab4 n10 n9 3.58639577403e-09
Ctab4 n9 0 4.96386958343e-13
Rtab5 n9 n12 0.032
Ltab5 n12 n11 3.58639577403e-09
Ctab5 n11 0 4.96386958343e-13
Rtab6 n11 n14 0.032
Ltab6 n14 n13 3.58639577403e-09
Ctab6 n13 0 4.96386958343e-13
Rtab7 n13 n16 0.032
Ltab7 n16 n15 3.58639577403e-09
Ctab7 n15 0 4.96386958343e-13
Rtab8 n15 n18 0.032
Ltab8 n18 n17 3.58639577403e-09
Ctab8 n17 0 4.96386958343e-13
Rtab9 n17 n19 0.032
Ltab9 n19 header 3.58639577403e-09
Ctab9 header 0 4.96386958343e-13
Rm0 header n21 0.0207965512115
Lm0 n21 n20 3.29049985496e-09
Cm0 n20 0 2.28506934372e-13
Rm1 n20 n22 0.0207965512115
Lm1 n22 swa0 3.29049985496e-09
Cm1 swa0 0 2.28506934372e-13
Lpka swa0 swa 3.553n
Csw_a swa 0 3.467e-12
Rswitch swa swb 4
Csw_b swb 0 3.467e-12
Lpkb swb swb0 3.553n
Riso0 swb0 n24 0.0214592929113
Liso0 n24 n23 3.39536106223e-09
Ciso0 n23 0 2.35788962655e-13
Riso1 n23 n25 0.0214592929113
Liso1 n25 iso 3.39536106223e-09
Ciso1 iso 0 2.35788962655e-13
Rseries iso after_r 680
Lseries after_r after_l .5n
Rf0 after_l n27 0.0273042327907
Lf0 n27 n26 4.32016698943e-09
Cf0 n26 0 3.00011596488e-13
Rf1 n26 n29 0.0273042327907
Lf1 n29 n28 4.32016698943e-09
Cf1 n28 0 3.00011596488e-13
Rf2 n28 n30 0.0273042327907
Lf2 n30 socket_a 4.32016698943e-09
Cf2 socket_a 0 3.00011596488e-13
Lsocket socket_a socket_b 2n
Csocket socket_b 0 1p
Rcore0 socket_b n32 0.032
Lcore0 n32 n31 3.58639577403e-09
Ccore0 n31 0 4.96386958343e-13
Rcore1 n31 n34 0.032
Lcore1 n34 n33 3.58639577403e-09
Ccore1 n33 0 4.96386958343e-13
Rcore2 n33 n36 0.032
Lcore2 n36 n35 3.58639577403e-09
Ccore2 n35 0 4.96386958343e-13
Rcore3 n35 n38 0.032
Lcore3 n38 n37 3.58639577403e-09
Ccore3 n37 0 4.96386958343e-13
Rcore4 n37 n40 0.032
Lcore4 n40 n39 3.58639577403e-09
Ccore4 n39 0 4.96386958343e-13
Rcore5 n39 n42 0.032
Lcore5 n42 n41 3.58639577403e-09
Ccore5 n41 0 4.96386958343e-13
Rcore6 n41 n44 0.032
Lcore6 n44 n43 3.58639577403e-09
Ccore6 n43 0 4.96386958343e-13
Rcore7 n43 n46 0.032
Lcore7 n46 n45 3.58639577403e-09
Ccore7 n45 0 4.96386958343e-13
Rcore8 n45 n48 0.032
Lcore8 n48 n47 3.58639577403e-09
Ccore8 n47 0 4.96386958343e-13
Rcore9 n47 n49 0.032
Lcore9 n49 core 3.58639577403e-09
Ccore9 core 0 4.96386958343e-13
Lvia host recv 4.5e-09
Cvia recv 0 1.5e-12
Vdrive drive 0 PULSE(0 3.465 10n 5e-10 5e-10 1e-07 2e-07)
Rdriver drive dpkg 10
Ldriver dpkg core 2n
Cin host 0 2e-12
Rleak host 0 1e9
.tran 20p 2.1e-07 0 20p
.save v(host) v(core) v(swa0) v(swb0)
.end
