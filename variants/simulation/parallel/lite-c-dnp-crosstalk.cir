Crosstalk distributed RLGC two traces over GND
.options reltol=1e-5 method=trap
Va da 0 PULSE(0 3.465 10n 3e-09 3e-09 200n 400n)
Ra da a0 60
Vv dv 0 0
Rv dv v0 60
Ra0 a0 ar0 .01
La0 ar0 a1 4.931641669930813e-10
Ca0 a1 0 6.126165339122572e-14
Rv0 v0 vr0 .01
Lv0 vr0 v1 4.931641669930813e-10
Cv0 v1 0 6.126165339122572e-14
K0 La0 Lv0 0.32992111034440846
Cmut0 a1 v1 1.7202300516260097e-14
Ra1 a1 ar1 .01
La1 ar1 a2 4.931641669930813e-10
Ca1 a2 0 6.126165339122572e-14
Rv1 v1 vr1 .01
Lv1 vr1 v2 4.931641669930813e-10
Cv1 v2 0 6.126165339122572e-14
K1 La1 Lv1 0.32992111034440846
Cmut1 a2 v2 1.7202300516260097e-14
Ra2 a2 ar2 .01
La2 ar2 a3 4.931641669930813e-10
Ca2 a3 0 6.126165339122572e-14
Rv2 v2 vr2 .01
Lv2 vr2 v3 4.931641669930813e-10
Cv2 v3 0 6.126165339122572e-14
K2 La2 Lv2 0.32992111034440846
Cmut2 a3 v3 1.7202300516260097e-14
Ra3 a3 ar3 .01
La3 ar3 a4 4.931641669930813e-10
Ca3 a4 0 6.126165339122572e-14
Rv3 v3 vr3 .01
Lv3 vr3 v4 4.931641669930813e-10
Cv3 v4 0 6.126165339122572e-14
K3 La3 Lv3 0.32992111034440846
Cmut3 a4 v4 1.7202300516260097e-14
Ra4 a4 ar4 .01
La4 ar4 a5 4.931641669930813e-10
Ca4 a5 0 6.126165339122572e-14
Rv4 v4 vr4 .01
Lv4 vr4 v5 4.931641669930813e-10
Cv4 v5 0 6.126165339122572e-14
K4 La4 Lv4 0.32992111034440846
Cmut4 a5 v5 1.7202300516260097e-14
Ra5 a5 ar5 .01
La5 ar5 a6 4.931641669930813e-10
Ca5 a6 0 6.126165339122572e-14
Rv5 v5 vr5 .01
Lv5 vr5 v6 4.931641669930813e-10
Cv5 v6 0 6.126165339122572e-14
K5 La5 Lv5 0.32992111034440846
Cmut5 a6 v6 1.7202300516260097e-14
Ra6 a6 ar6 .01
La6 ar6 a7 4.931641669930813e-10
Ca6 a7 0 6.126165339122572e-14
Rv6 v6 vr6 .01
Lv6 vr6 v7 4.931641669930813e-10
Cv6 v7 0 6.126165339122572e-14
K6 La6 Lv6 0.32992111034440846
Cmut6 a7 v7 1.7202300516260097e-14
Ra7 a7 ar7 .01
La7 ar7 a8 4.931641669930813e-10
Ca7 a8 0 6.126165339122572e-14
Rv7 v7 vr7 .01
Lv7 vr7 v8 4.931641669930813e-10
Cv7 v8 0 6.126165339122572e-14
K7 La7 Lv7 0.32992111034440846
Cmut7 a8 v8 1.7202300516260097e-14
Ra8 a8 ar8 .01
La8 ar8 a9 4.931641669930813e-10
Ca8 a9 0 6.126165339122572e-14
Rv8 v8 vr8 .01
Lv8 vr8 v9 4.931641669930813e-10
Cv8 v9 0 6.126165339122572e-14
K8 La8 Lv8 0.32992111034440846
Cmut8 a9 v9 1.7202300516260097e-14
Ra9 a9 ar9 .01
La9 ar9 a10 4.931641669930813e-10
Ca9 a10 0 6.126165339122572e-14
Rv9 v9 vr9 .01
Lv9 vr9 v10 4.931641669930813e-10
Cv9 v10 0 6.126165339122572e-14
K9 La9 Lv9 0.32992111034440846
Cmut9 a10 v10 1.7202300516260097e-14
Ra10 a10 ar10 .01
La10 ar10 a11 4.931641669930813e-10
Ca10 a11 0 6.126165339122572e-14
Rv10 v10 vr10 .01
Lv10 vr10 v11 4.931641669930813e-10
Cv10 v11 0 6.126165339122572e-14
K10 La10 Lv10 0.32992111034440846
Cmut10 a11 v11 1.7202300516260097e-14
Ra11 a11 ar11 .01
La11 ar11 a12 4.931641669930813e-10
Ca11 a12 0 6.126165339122572e-14
Rv11 v11 vr11 .01
Lv11 vr11 v12 4.931641669930813e-10
Cv11 v12 0 6.126165339122572e-14
K11 La11 Lv11 0.32992111034440846
Cmut11 a12 v12 1.7202300516260097e-14
Ca a12 0 20p
Cv v12 0 20p
Rseries v12 vr 680
Cinput vr 0 8p
.tran 10p 150n 0 10p
.save v(vr) v(v0) v(a0)
.end
