calibration-vendor-EVM
.include "D:/github/airpocket-soundman/tab5-tang-primer20k-carrier-audit-pages/variants/simulation/power/models/TPS5430_TRANS.LIB"
.param temper=25
.temp 25
Vsource supply 0 PWL(0 0 0.0002 15 45m 15)
Rsource supply dc 0.01
Rptc dc dc_protected 0.001
Rdirect dc_protected vin .001
.model D54 D(Is=50u Rs=.02 N=1.2 Cjo=200p Tt=8n Bv=40 Ibv=1m)
Rbulk vin cbulk .3
Cbulk cbulk 0 0.0001
Rceramic vin ccer .01
Cceramic ccer 0 1.2e-05
Rena vin en 100k
Renb en 0 15k
Vswitch swcontrol 0 0
Soff en 0 swcontrol 0 SWOFF
.model SWOFF SW(Ron=.1 Roff=1e12 Vt=.5 Vh=.1)
Rtop vout fb 10000.0
Rbot fb 0 3293.46
Rtrim1 fb rtrim 99801.81818181818
Rtrim2 rtrim 0 99801.81818181818
XU boot en 0 nc nc1 0 ph vin fb TPS5430_TRANS MODE=0
Cboot boot ph 10n
Dcatch 0 ph D54
Rl ph li 0.027
L1 li vout 1.5e-05
Resr vout capout 0.02
Cout capout 0 0.00022
Rpath vout vcore 0.001
Ccore vcore 0 1e-05
Vload load0 0 PWL(0 0.75 0.009 0.75 0.009000999999999999 2.25 0.01 2.25 0.010001 0.75 .045 0.75)
Bcore vcore 0 I={max(V(vcore),0)*V(load0)/5}
Rbleed vout 0 10k
Bhdmi vout 0 I={max(V(vout),0)*0/5}
R33dummy v33raw 0 1k
Ractive_dummy active 0 1k
.options reltol=.002 abstol=1n vntol=10u itl4=200 method=gear
.save v(vout) v(vcore) v(v33raw) v(vin) v(en) i(L1) i(Vsource)
.tran 1e-07 0.0115 0 1e-07 uic
.end
