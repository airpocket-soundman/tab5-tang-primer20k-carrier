lite-a-dual-combined-loop-worst
.func clamp(x,a,b) {min(max(x,a),b)}
.func sel(a,b,c) {a?b:c}
.include "D:/github/airpocket-soundman/tab5-tang-primer20k-carrier-audit-pages/variants/simulation/power/models/TPS5430_TRANS.LIB"
.param temper=25
.temp 25
Vsource supply 0 PWL(0 0 0.0002 11.4 45m 11.4)
Rsource supply dc 0.2
Rptc dc dc_protected 0.05
Dinput dc_protected vin D54
.model D54 D(Is=50u Rs=.02 N=1.2 Cjo=200p Tt=8n Bv=40 Ibv=1m)
Dtvs 0 vin TVS15
.model TVS15 D(Is=1n N=1.5 Rs=.1 Bv=18 Ibv=1m Cjo=1n)
Rbulk vin cbulk .3
Cbulk cbulk 0 0.0001
Rceramic vin ccer .01
Cceramic ccer 0 1.2e-05
Rena vin en 100k
Renb en 0 15k
Vswitch swcontrol 0 0
Soff en 0 swcontrol 0 SWOFF
.model SWOFF SW(Ron=.1 Roff=1e12 Vt=.5 Vh=.1)
Rtop vout fb 9900.0
Rbot fb 0 3333.0
Rtrim1 fb rtrim 101000.0
Rtrim2 rtrim 0 101000.0
Benpull vin en I={5u*clamp(V(vin),0,1)}
* Derived from TI TPS5430_TRANS compensation R/C and opamp parameters
Veref eref 0 1.196
Bss 0 ss I={sel(V(active)>.5,V(eref)*.001,-V(ss))}
Css ss 0 8e-06
Rss ss 0 1G
Bref ref 0 V={min(max(V(ss),0),V(eref))}
R_EA3 ea ea_r3 3.27Meg
R_EA1 fb ea_r1 260k
C_EA2 ea_r3 ea_in 30p
C_EA1 ea_r1 ea_in 20p
R_EA2 fb ea_in 2.75Meg
C_EA3 ea ea_in 1p
V_EA vdd 0 3.3
Xea ref ea_in vdd 0 ea stdopamp GAIN=206.538K RIN=20MEG RINC=1E9 ROUT=1 SLEWRATE=1.5Meg FPOLE1=14.96 FPOLE2=10MEG VDROPOH=0 VDROPOL=0 VOFFS=0 IBIAS=0 IOFFS=0
Venth enth 0 1.15
Venhys enhys 0 0.45
Vvinth vinth 0 5.3
Vvinhys vinhys 0 .33
Xena en enth enhys enstate COMPHYS_BASIC_GEN
Xvin vin vinth vinhys vinstate COMPHYS_BASIC_GEN
Bactive active 0 V={sel((V(enstate)>.5)&&(V(vinstate)>.5),1,0)}
B_duty dutycommand 0 V={sel((V(active)>.5)&&(V(fb)<1.125*V(eref)),clamp((V(ea)-.3)/max(.0375*V(vin),.05),0,.87)*clamp((4-I(L1))/.2,0,1),0)}
R_duty dutycommand duty 1
C_duty duty 0 1.25e-06
B_ph phdrv 0 V={V(duty)*V(vin)-(1-V(duty))*.4}
R_switch phdrv ph .1
Dav ph li_block DAVG
.model DAVG D(Is=1p Rs=.0001 N=.01 Eg=0 Xti=0 Tnom=25)
Bin vin 0 I={max(0,V(duty)*I(L1))+(.003*V(active)+15u*(1-V(active)))*clamp(V(vin),0,1)}
Rl li_block li 0.045
L1 li vout 1.2e-05
Resr vout capout 0.002
Cout capout 0 0.000176
Rpath vout vcore 0.22167592763569147
Ccore vcore 0 1e-05
Vload load0 0 PWL(0 0.05 0.02 0.05 0.020001 0.5 0.035 0.5 0.035001000000000004 0.05 0.045000000000000005 0.05)
Bcore vcore 0 I={clamp(V(vcore),0,1)*V(load0)}
Rbleed vout 0 10k
Bhdmi vout 0 I={max(V(vout),0)*0.05/5}
* XC6206 typical family load-transient fit, NOT vendor transistor model
R_ldoin vout ldo_lin .008
L_ldoin ldo_lin ldo_vin 6e-09
R_c10 ldo_vin c10internal .01
C_c10 c10internal 0 6.4e-06
B_ldoref ldoref 0 V={min(3.3,max(0,V(ldo_vin)-.25))}
B_pi_cmd icmd 0 V={0.04635*(V(ldoref)-V(v33raw))+V(integ)}
R_passdriver icmd passcmd 1
C_passdriver passcmd 0 200n
C_ldo_pin v33raw 0 100p
B_integ 0 integ I={1271.95*(V(ldoref)-V(v33raw))*clamp((V(ldo_vin)-1.8)/.1,0,1)+10000*(clamp(V(icmd),0,.2)-V(icmd))-(1-clamp((V(ldo_vin)-1.8)/.1,0,1))*V(integ)/.01}
C_integ integ 0 1
R_integ integ 0 1G
B_pass ldo_vin v33raw I={clamp(V(passcmd),0,.2)*clamp((V(ldo_vin)-V(v33raw))/.25,0,1)}
D_ldoreverse v33raw ldo_vin DREV
.model DREV D(Is=1n N=1.2 Rs=1)
R33trace v33raw v33lc 0.011
L33trace v33lc c33in 6e-09
R33esr c33in c33int .01
C33 c33int 0 2.2e-05
B33load v33raw 0 I={clamp(V(v33raw),0,1)*V(ldocurrent)}
Vldocurrent ldocurrent 0 PWL(0 0.01 28m 0.01 28.001m 0.01 45m 0.01)
.options reltol=.002 abstol=1n vntol=10u itl4=200 method=gear
.save v(vout) v(vcore) v(v33raw) v(vin) v(en) v(active) i(L1) i(Vsource)
.tran 2e-06 0.045 0 2e-06 uic
.end
