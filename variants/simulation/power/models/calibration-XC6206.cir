XC6206 family 3V typical-curve calibration
.func clamp(x,a,b) {min(max(x,a),b)}
.func sel(a,b,c) {a?b:c}
Vsource vout 0 4
* XC6206 typical family load-transient fit, NOT vendor transistor model
R_ldoin vout ldo_lin .008
L_ldoin ldo_lin ldo_vin 1e-09
R_c10 ldo_vin c10internal .01
C_c10 c10internal 0 1e-06
B_ldoref ldoref 0 V={min(3.0,max(0,V(ldo_vin)-.25))}
B_pi_cmd icmd 0 V={0.04635*(V(ldoref)-V(v33raw))+V(integ)}
R_passdriver icmd passcmd 1
C_passdriver passcmd 0 200n
C_ldo_pin v33raw 0 100p
B_integ 0 integ I={1271.95*(V(ldoref)-V(v33raw))*clamp((V(ldo_vin)-1.8)/.1,0,1)+10000*(clamp(V(icmd),0,.2)-V(icmd))-(1-clamp((V(ldo_vin)-1.8)/.1,0,1))*V(integ)/.01}
C_integ integ 0 1
R_integ integ 0 1G
B_pass ldo_vin v33raw I={clamp(V(passcmd),0,.2)*clamp((V(ldo_vin)-V(v33raw))/.25,0,1)}
D_ldoreverse v33raw ldo_vin DREV
.model DREV D(Is=1n N=1.2 Rs=1)
R33trace v33raw v33lc 0.001
L33trace v33lc c33in 1e-09
R33esr c33in c33int .01
C33 c33int 0 1e-06
B33load v33raw 0 I={clamp(V(v33raw),0,1)*V(ldocurrent)}
Vldocurrent ldocurrent 0 PWL(0 .001 2m .001 2.001m .040 4m .040 4.001m .001 6m .001)
.ic V(ldo_vin)=4 V(c10internal)=4 V(passcmd)=.001 V(v33raw)=3 V(c33int)=3 V(integ)=.001
.options method=gear reltol=.002 abstol=1n rshunt=1e12
.save v(v33raw) v(ldocurrent)
.tran 1u 6m 0 1u uic
.end
