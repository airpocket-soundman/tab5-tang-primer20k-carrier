Active-low HPD proposal: NPN buffer
Vrail v33 0 0
Vcore core 0 0
R40 hpd base 47470.0
R41 base 0 99000.0
R51 v33 pin 47470.0
Q5 pin base 0 Q3904
.model Q3904 NPN(IS=1e-14 BF=20 BR=1 VAF=100 IKF=.1 RB=10 RC=1 RE=1 CJE=10p CJC=8e-12 TF=.4n TR=100n)
R_esd hpd 0 5meg
Cpin pin 0 5e-12
I_input pin 0 0
Bcbo pin base I=50n*tanh(max(v(pin,base),0)/.1)
.model GPIOclamp D(IS=1e-9 N=1 RS=1)
.options reltol=1e-5 abstol=1e-12 vntol=1e-7
.save all
Dupper pin core GPIOclamp
.save @dupper[id]
Vh source 0 PULSE(0 5.5 100u 10n 10n 2m 100m)
Rsource source hpd 1000
.tran 1u 12m 0 1u
.end
