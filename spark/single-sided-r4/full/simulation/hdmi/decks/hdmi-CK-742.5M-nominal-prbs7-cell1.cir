HDMI CK 742500000.0 nominal prbs7 coupled RLGC analytical driver
* Engineering waveform evaluation; not HDMI compliance, IBIS or a cable model.
Vterm vterm 0 3.3
Vsrcp srcp 0 PWL(0 1.2 1.3468013468013e-09 1.2 1.3468013468013e-09 1.2 1.4668013468013e-09 1.55 8.0808080808081e-09 1.55 8.2008080808081e-09 0.85 1.4814814814815e-08 0.85 1.4934814814815e-08 1.55 2.1548821548822e-08 1.55 2.1668821548822e-08 0.85 2.8282828282828e-08 0.85 2.8402828282828e-08 1.55 3.5016835016835e-08 1.55 3.5136835016835e-08 0.85 4.1750841750842e-08 0.85 4.1870841750842e-08 1.55 4.8484848484848e-08 1.55 4.8604848484848e-08 0.85 5.5218855218855e-08 0.85 5.5338855218855e-08 1.55 6.1952861952862e-08 1.55 6.2072861952862e-08 0.85 6.8686868686869e-08 0.85 6.8806868686869e-08 1.55 7.5420875420875e-08 1.55 7.5540875420875e-08 0.85 8.2154882154882e-08 0.85 8.2274882154882e-08 1.55 8.8888888888889e-08 1.55 8.9008888888889e-08 0.85 9.5622895622896e-08 0.85 9.5742895622896e-08 1.55 1.023569023569e-07 1.55 1.024769023569e-07 0.85 1.0909090909091e-07 0.85 1.0921090909091e-07 1.55 1.1582491582492e-07 1.55 1.1594491582492e-07 0.85 1.2255892255892e-07 0.85 1.2267892255892e-07 1.55 1.2929292929293e-07 1.55 1.2941292929293e-07 0.85 1.3602693602694e-07 0.85 1.3614693602694e-07 1.55 1.4276094276094e-07 1.55 1.4288094276094e-07 0.85 1.4949494949495e-07 0.85 1.4961494949495e-07 1.55 1.5622895622896e-07 1.55 1.5634895622896e-07 0.85 1.6296296296296e-07 0.85 1.6308296296296e-07 1.55 1.6969696969697e-07 1.55 1.6981696969697e-07 0.85 1.7373737373737e-07 0.85)
Rsrcp srcp txp 50.0
Vsrcn srcn 0 PWL(0 1.2 1.3468013468013e-09 1.2 1.3468013468013e-09 1.2 1.4668013468013e-09 0.85 8.0808080808081e-09 0.85 8.2008080808081e-09 1.55 1.4814814814815e-08 1.55 1.4934814814815e-08 0.85 2.1548821548822e-08 0.85 2.1668821548822e-08 1.55 2.8282828282828e-08 1.55 2.8402828282828e-08 0.85 3.5016835016835e-08 0.85 3.5136835016835e-08 1.55 4.1750841750842e-08 1.55 4.1870841750842e-08 0.85 4.8484848484848e-08 0.85 4.8604848484848e-08 1.55 5.5218855218855e-08 1.55 5.5338855218855e-08 0.85 6.1952861952862e-08 0.85 6.2072861952862e-08 1.55 6.8686868686869e-08 1.55 6.8806868686869e-08 0.85 7.5420875420875e-08 0.85 7.5540875420875e-08 1.55 8.2154882154882e-08 1.55 8.2274882154882e-08 0.85 8.8888888888889e-08 0.85 8.9008888888889e-08 1.55 9.5622895622896e-08 1.55 9.5742895622896e-08 0.85 1.023569023569e-07 0.85 1.024769023569e-07 1.55 1.0909090909091e-07 1.55 1.0921090909091e-07 0.85 1.1582491582492e-07 0.85 1.1594491582492e-07 1.55 1.2255892255892e-07 1.55 1.2267892255892e-07 0.85 1.2929292929293e-07 0.85 1.2941292929293e-07 1.55 1.3602693602694e-07 1.55 1.3614693602694e-07 0.85 1.4276094276094e-07 0.85 1.4288094276094e-07 1.55 1.4949494949495e-07 1.55 1.4961494949495e-07 0.85 1.5622895622896e-07 0.85 1.5634895622896e-07 1.55 1.6296296296296e-07 1.55 1.6308296296296e-07 0.85 1.6969696969697e-07 0.85 1.6981696969697e-07 1.55 1.7373737373737e-07 1.55)
Rsrcn srcn txn 50.0
Rp0 txp rp0 0.0241290564866
Lp0 rp0 p0 5.54639962045e-10
Cgp0 p0 0 2.21855984818e-13
Rgp0 p0 0 96616.7723093
Rn0 txn rn0 0.0241290564866
Ln0 rn0 n0 5.54639962045e-10
Cgn0 n0 0 2.21855984818e-13
Rgn0 n0 0 96616.7723093
Rp1 p0 rp1 0.0241290564866
Lp1 rp1 p1 5.54639962045e-10
Cgp1 p1 0 2.21855984818e-13
Rgp1 p1 0 96616.7723093
Rn1 n0 rn1 0.0241290564866
Ln1 rn1 n1 5.54639962045e-10
Cgn1 n1 0 2.21855984818e-13
Rgn1 n1 0 96616.7723093
Rp2 p1 rp2 0.0241290564866
Lp2 rp2 p2 5.54639962045e-10
Cgp2 p2 0 2.21855984818e-13
Rgp2 p2 0 96616.7723093
Rn2 n1 rn2 0.0241290564866
Ln2 rn2 n2 5.54639962045e-10
Cgn2 n2 0 2.21855984818e-13
Rgn2 n2 0 96616.7723093
Rp3 p2 rp3 0.0241290564866
Lp3 rp3 p3 5.54639962045e-10
Cgp3 p3 0 2.21855984818e-13
Rgp3 p3 0 96616.7723093
Rn3 n2 rn3 0.0241290564866
Ln3 rn3 n3 5.54639962045e-10
Cgn3 n3 0 2.21855984818e-13
Rgn3 n3 0 96616.7723093
Rp4 p3 rp4 0.0241290564866
Lp4 rp4 p4 5.54639962045e-10
Cgp4 p4 0 2.21855984818e-13
Rgp4 p4 0 96616.7723093
Rn4 n3 rn4 0.0241290564866
Ln4 rn4 n4 5.54639962045e-10
Cgn4 n4 0 2.21855984818e-13
Rgn4 n4 0 96616.7723093
Rp5 p4 rp5 0.0241290564866
Lp5 rp5 p5 5.54639962045e-10
Cgp5 p5 0 2.21855984818e-13
Rgp5 p5 0 96616.7723093
Rn5 n4 rn5 0.0241290564866
Ln5 rn5 n5 5.54639962045e-10
Cgn5 n5 0 2.21855984818e-13
Rgn5 n5 0 96616.7723093
Rp6 p5 rp6 0.0241290564866
Lp6 rp6 p6 5.54639962045e-10
Cgp6 p6 0 2.21855984818e-13
Rgp6 p6 0 96616.7723093
Rn6 n5 rn6 0.0241290564866
Ln6 rn6 n6 5.54639962045e-10
Cgn6 n6 0 2.21855984818e-13
Rgn6 n6 0 96616.7723093
Rp7 p6 rp7 0.0241290564866
Lp7 rp7 p7 5.54639962045e-10
Cgp7 p7 0 2.21855984818e-13
Rgp7 p7 0 96616.7723093
Rn7 n6 rn7 0.0241290564866
Ln7 rn7 n7 5.54639962045e-10
Cgn7 n7 0 2.21855984818e-13
Rgn7 n7 0 96616.7723093
Rp8 p7 rp8 0.0241290564866
Lp8 rp8 p8 5.54639962045e-10
Cgp8 p8 0 2.21855984818e-13
Rgp8 p8 0 96616.7723093
Rn8 n7 rn8 0.0241290564866
Ln8 rn8 n8 5.54639962045e-10
Cgn8 n8 0 2.21855984818e-13
Rgn8 n8 0 96616.7723093
Rp9 p8 rp9 0.0241290564866
Lp9 rp9 p9 5.54639962045e-10
Cgp9 p9 0 2.21855984818e-13
Rgp9 p9 0 96616.7723093
Rn9 n8 rn9 0.0241290564866
Ln9 rn9 n9 5.54639962045e-10
Cgn9 n9 0 2.21855984818e-13
Rgn9 n9 0 96616.7723093
Rp10 p9 rp10 0.0241290564866
Lp10 rp10 p10 5.54639962045e-10
Cgp10 p10 0 2.21855984818e-13
Rgp10 p10 0 96616.7723093
Rn10 n9 rn10 0.0241290564866
Ln10 rn10 n10 5.54639962045e-10
Cgn10 n10 0 2.21855984818e-13
Rgn10 n10 0 96616.7723093
Rp11 p10 rp11 0.0241290564866
Lp11 rp11 p11 5.54639962045e-10
Cgp11 p11 0 2.21855984818e-13
Rgp11 p11 0 96616.7723093
Rn11 n10 rn11 0.0241290564866
Ln11 rn11 n11 5.54639962045e-10
Cgn11 n11 0 2.21855984818e-13
Rgn11 n11 0 96616.7723093
Rp12 p11 rp12 0.0241290564866
Lp12 rp12 p12 5.54639962045e-10
Cgp12 p12 0 2.21855984818e-13
Rgp12 p12 0 96616.7723093
Rn12 n11 rn12 0.0241290564866
Ln12 rn12 n12 5.54639962045e-10
Cgn12 n12 0 2.21855984818e-13
Rgn12 n12 0 96616.7723093
Rp13 p12 rp13 0.0241290564866
Lp13 rp13 p13 5.54639962045e-10
Cgp13 p13 0 2.21855984818e-13
Rgp13 p13 0 96616.7723093
Rn13 n12 rn13 0.0241290564866
Ln13 rn13 n13 5.54639962045e-10
Cgn13 n13 0 2.21855984818e-13
Rgn13 n13 0 96616.7723093
Rp14 p13 rp14 0.0241290564866
Lp14 rp14 p14 5.54639962045e-10
Cgp14 p14 0 2.21855984818e-13
Rgp14 p14 0 96616.7723093
Rn14 n13 rn14 0.0241290564866
Ln14 rn14 n14 5.54639962045e-10
Cgn14 n14 0 2.21855984818e-13
Rgn14 n14 0 96616.7723093
Rp15 p14 rp15 0.0241290564866
Lp15 rp15 p15 5.54639962045e-10
Cgp15 p15 0 2.21855984818e-13
Rgp15 p15 0 96616.7723093
Rn15 n14 rn15 0.0241290564866
Ln15 rn15 n15 5.54639962045e-10
Cgn15 n15 0 2.21855984818e-13
Rgn15 n15 0 96616.7723093
Rp16 p15 rp16 0.0241290564866
Lp16 rp16 p16 5.54639962045e-10
Cgp16 p16 0 2.21855984818e-13
Rgp16 p16 0 96616.7723093
Rn16 n15 rn16 0.0241290564866
Ln16 rn16 n16 5.54639962045e-10
Cgn16 n16 0 2.21855984818e-13
Rgn16 n16 0 96616.7723093
Rp17 p16 rp17 0.0241290564866
Lp17 rp17 p17 5.54639962045e-10
Cgp17 p17 0 2.21855984818e-13
Rgp17 p17 0 96616.7723093
Rn17 n16 rn17 0.0241290564866
Ln17 rn17 n17 5.54639962045e-10
Cgn17 n17 0 2.21855984818e-13
Rgn17 n17 0 96616.7723093
Rp18 p17 rp18 0.0241290564866
Lp18 rp18 p18 5.54639962045e-10
Cgp18 p18 0 2.21855984818e-13
Rgp18 p18 0 96616.7723093
Rn18 n17 rn18 0.0241290564866
Ln18 rn18 n18 5.54639962045e-10
Cgn18 n18 0 2.21855984818e-13
Rgn18 n18 0 96616.7723093
Rp19 p18 rp19 0.0241290564866
Lp19 rp19 p19 5.54639962045e-10
Cgp19 p19 0 2.21855984818e-13
Rgp19 p19 0 96616.7723093
Rn19 n18 rn19 0.0241290564866
Ln19 rn19 n19 5.54639962045e-10
Cgn19 n19 0 2.21855984818e-13
Rgn19 n19 0 96616.7723093
Lsocketp p19 socketp 7e-10
Csocketp socketp 0 7e-13
Lsocketn n19 socketn 7e-10
Csocketn socketn 0 7e-13
Rp20 socketp rp20 0.0121370314178
Lp20 rp20 p20 4.56029071926e-10
Cgp20 p20 0 6.31617934908e-14
Rgp20 p20 0 339366.696003
Rn20 socketn rn20 0.0121370314178
Ln20 rn20 n20 4.56029071926e-10
Cgn20 n20 0 6.31617934908e-14
Rgn20 n20 0 339366.696003
K20 Lp20 Ln20 0.0931882060747
Cm20 p20 n20 2.2813476877e-15
Rp21 p20 rp21 0.0134253542407
Lp21 rp21 p21 4.57541060878e-10
Cgp21 p21 0 7.77629926692e-14
Rgp21 p21 0 275645.373652
Rn21 n20 rn21 0.0134253542407
Ln21 rn21 n21 4.57541060878e-10
Cgn21 n21 0 7.77629926692e-14
Rgn21 n21 0 275645.373652
K21 Lp21 Ln21 0.117219632643
Cm21 p21 n21 3.94048617967e-15
Rp22 p21 rp22 0.0119663210269
Lp22 rp22 p22 3.76349273682e-10
Cgp22 p22 0 7.08846474659e-14
Rgp22 p22 0 302392.83028
Rn22 n21 rn22 0.0119663210269
Ln22 rn22 n22 3.76349273682e-10
Cgn22 n22 0 7.08846474659e-14
Rgn22 n22 0 302392.83028
K22 Lp22 Ln22 0.22128817995
Cm22 p22 n22 1.00611370707e-14
Rp23 p22 rp23 0.0125816362029
Lp23 rp23 p23 3.92211344158e-10
Cgp23 p23 0 7.11807209309e-14
Rgp23 p23 0 301135.038958
Rn23 n22 rn23 0.0125816362029
Ln23 rn23 n23 3.92211344158e-10
Cgn23 n23 0 7.11807209309e-14
Rgn23 n23 0 301135.038958
K23 Lp23 Ln23 0.294224797804
Cm23 p23 n23 1.61704657848e-14
Rp24 p23 rp24 0.0125816362029
Lp24 rp24 p24 3.92222189681e-10
Cgp24 p24 0 7.11886170883e-14
Rgp24 p24 0 301101.637415
Rn24 n23 rn24 0.0125816362029
Ln24 rn24 n24 3.92222189681e-10
Cgn24 n24 0 7.11886170883e-14
Rgn24 n24 0 301101.637415
K24 Lp24 Ln24 0.294044791441
Cm24 p24 n24 1.61554210706e-14
Rp25 p24 rp25 0.0125816362029
Lp25 rp25 p25 3.92242859629e-10
Cgp25 p25 0 7.12036664092e-14
Rgp25 p25 0 301037.997783
Rn25 n24 rn25 0.0125816362029
Ln25 rn25 n25 3.92242859629e-10
Cgn25 n25 0 7.12036664092e-14
Rgn25 n25 0 301037.997783
K25 Lp25 Ln25 0.293701835
Cm25 p25 n25 1.61267692057e-14
Rp26 p25 rp26 0.0125816362029
Lp26 rp26 p26 3.92273288476e-10
Cgp26 p26 0 7.12258219846e-14
Rgp26 p26 0 300944.356603
Rn26 n25 rn26 0.0125816362029
Ln26 rn26 n26 3.92273288476e-10
Cgn26 n26 0 7.12258219846e-14
Rgn26 n26 0 300944.356603
K26 Lp26 Ln26 0.293197217974
Cm26 p26 n26 1.60846402184e-14
Rp27 p26 rp27 0.0125816362029
Lp27 rp27 p27 3.92313380367e-10
Cgp27 p27 0 7.12550152008e-14
Rgp27 p27 0 300821.059545
Rn27 n26 rn27 0.0125816362029
Ln27 rn27 n27 3.92313380367e-10
Cgn27 n27 0 7.12550152008e-14
Rgn27 n27 0 300821.059545
K27 Lp27 Ln27 0.292532824732
Cm27 p27 n27 1.60292237889e-14
Rp28 p27 rp28 0.0129739333521
Lp28 rp28 p28 4.04602559093e-10
Cgp28 p28 0 7.35181146453e-14
Rgp28 p28 0 291560.92038
Rn28 n27 rn28 0.0129739333521
Ln28 rn28 n28 4.04602559093e-10
Cgn28 n28 0 7.35181146453e-14
Rgn28 n28 0 291560.92038
K28 Lp28 Ln28 0.291620985826
Cm28 p28 n28 1.64506885886e-14
Rp29 p28 rp29 0.01211678665
Lp29 rp29 p29 3.77934263869e-10
Cgp29 p29 0 6.87065354045e-14
Rgp29 p29 0 311979.188652
Rn29 n28 rn29 0.01211678665
Ln29 rn29 n29 3.77934263869e-10
Cgn29 n29 0 6.87065354045e-14
Rgn29 n29 0 311979.188652
K29 Lp29 Ln29 0.29054757667
Cm29 p29 n29 1.52778634366e-14
Rp30 p29 rp30 0.0126107020997
Lp30 rp30 p30 3.93283691458e-10
Cgp30 p30 0 7.14662302799e-14
Rgp30 p30 0 299931.997066
Rn30 n29 rn30 0.0126107020997
Ln30 rn30 n30 3.93283691458e-10
Cgn30 n30 0 7.14662302799e-14
Rgn30 n30 0 299931.997066
K30 Lp30 Ln30 0.291475863148
Cm30 p30 n30 1.59780115097e-14
Rp31 p30 rp31 0.0126107020997
Lp31 rp31 p31 3.93283691458e-10
Cgp31 p31 0 7.14662302799e-14
Rgp31 p31 0 299931.997066
Rn31 n30 rn31 0.0126107020997
Ln31 rn31 n31 3.93283691458e-10
Cgn31 n31 0 7.14662302799e-14
Rgn31 n31 0 299931.997066
K31 Lp31 Ln31 0.291475863148
Cm31 p31 n31 1.59780115097e-14
Rp32 p31 rp32 0.0126107020997
Lp32 rp32 p32 3.93283691458e-10
Cgp32 p32 0 7.14662302799e-14
Rgp32 p32 0 299931.997066
Rn32 n31 rn32 0.0126107020997
Ln32 rn32 n32 3.93283691458e-10
Cgn32 n32 0 7.14662302799e-14
Rgn32 n32 0 299931.997066
K32 Lp32 Ln32 0.291475863148
Cm32 p32 n32 1.59780115097e-14
Rp33 p32 rp33 0.0126107020997
Lp33 rp33 p33 3.93283691458e-10
Cgp33 p33 0 7.14662302799e-14
Rgp33 p33 0 299931.997066
Rn33 n32 rn33 0.0126107020997
Ln33 rn33 n33 3.93283691458e-10
Cgn33 n33 0 7.14662302799e-14
Rgn33 n33 0 299931.997066
K33 Lp33 Ln33 0.291475863148
Cm33 p33 n33 1.59780115097e-14
Rp34 p33 rp34 0.0126107020997
Lp34 rp34 p34 3.93283691458e-10
Cgp34 p34 0 7.14662302799e-14
Rgp34 p34 0 299931.997066
Rn34 n33 rn34 0.0126107020997
Ln34 rn34 n34 3.93283691458e-10
Cgn34 n34 0 7.14662302799e-14
Rgn34 n34 0 299931.997066
K34 Lp34 Ln34 0.291475863148
Cm34 p34 n34 1.59780115097e-14
Rp35 p34 rp35 0.0126107020997
Lp35 rp35 p35 3.93283691458e-10
Cgp35 p35 0 7.14662302799e-14
Rgp35 p35 0 299931.997066
Rn35 n34 rn35 0.0126107020997
Ln35 rn35 n35 3.93283691458e-10
Cgn35 n35 0 7.14662302799e-14
Rgn35 n35 0 299931.997066
K35 Lp35 Ln35 0.291475863148
Cm35 p35 n35 1.59780115097e-14
Rp36 p35 rp36 0.0126107020997
Lp36 rp36 p36 3.93283691458e-10
Cgp36 p36 0 7.14662302799e-14
Rgp36 p36 0 299931.997066
Rn36 n35 rn36 0.0126107020997
Ln36 rn36 n36 3.93283691458e-10
Cgn36 n36 0 7.14662302799e-14
Rgn36 n36 0 299931.997066
K36 Lp36 Ln36 0.291475863148
Cm36 p36 n36 1.59780115097e-14
Rp37 p36 rp37 0.0126107020997
Lp37 rp37 p37 3.93283691458e-10
Cgp37 p37 0 7.14662302799e-14
Rgp37 p37 0 299931.997066
Rn37 n36 rn37 0.0126107020997
Ln37 rn37 n37 3.93283691458e-10
Cgn37 n37 0 7.14662302799e-14
Rgn37 n37 0 299931.997066
K37 Lp37 Ln37 0.291475863148
Cm37 p37 n37 1.59780115097e-14
Rp38 p37 rp38 0.0113496318898
Lp38 rp38 p38 3.53955322312e-10
Cgp38 p38 0 6.43196072519e-14
Rgp38 p38 0 333257.774518
Rn38 n37 rn38 0.0113496318898
Ln38 rn38 n38 3.53955322312e-10
Cgn38 n38 0 6.43196072519e-14
Rgn38 n38 0 333257.774518
K38 Lp38 Ln38 0.291475863148
Cm38 p38 n38 1.43802103588e-14
Rp39 p38 rp39 0.0126107020997
Lp39 rp39 p39 3.93283691458e-10
Cgp39 p39 0 7.14662302799e-14
Rgp39 p39 0 299931.997066
Rn39 n38 rn39 0.0126107020997
Ln39 rn39 n39 3.93283691458e-10
Cgn39 n39 0 7.14662302799e-14
Rgn39 n39 0 299931.997066
K39 Lp39 Ln39 0.291475863148
Cm39 p39 n39 1.59780115097e-14
Rp40 p39 rp40 0.0126107020997
Lp40 rp40 p40 3.93283691458e-10
Cgp40 p40 0 7.14662302799e-14
Rgp40 p40 0 299931.997066
Rn40 n39 rn40 0.0126107020997
Ln40 rn40 n40 3.93283691458e-10
Cgn40 n40 0 7.14662302799e-14
Rgn40 n40 0 299931.997066
K40 Lp40 Ln40 0.291475863148
Cm40 p40 n40 1.59780115097e-14
Rp41 p40 rp41 0.0126107020997
Lp41 rp41 p41 3.93283691458e-10
Cgp41 p41 0 7.14662302799e-14
Rgp41 p41 0 299931.997066
Rn41 n40 rn41 0.0126107020997
Ln41 rn41 n41 3.93283691458e-10
Cgn41 n41 0 7.14662302799e-14
Rgn41 n41 0 299931.997066
K41 Lp41 Ln41 0.291475863148
Cm41 p41 n41 1.59780115097e-14
Rp42 p41 rp42 0.0126107020997
Lp42 rp42 p42 3.93283691458e-10
Cgp42 p42 0 7.14662302799e-14
Rgp42 p42 0 299931.997066
Rn42 n41 rn42 0.0126107020997
Ln42 rn42 n42 3.93283691458e-10
Cgn42 n42 0 7.14662302799e-14
Rgn42 n42 0 299931.997066
K42 Lp42 Ln42 0.291475863148
Cm42 p42 n42 1.59780115097e-14
Rp43 p42 rp43 0.0126107020997
Lp43 rp43 p43 3.93283691458e-10
Cgp43 p43 0 7.14662302799e-14
Rgp43 p43 0 299931.997066
Rn43 n42 rn43 0.0126107020997
Ln43 rn43 n43 3.93283691458e-10
Cgn43 n43 0 7.14662302799e-14
Rgn43 n43 0 299931.997066
K43 Lp43 Ln43 0.291475863148
Cm43 p43 n43 1.59780115097e-14
Rp44 p43 rp44 0.0126107020997
Lp44 rp44 p44 3.93283691458e-10
Cgp44 p44 0 7.14662302799e-14
Rgp44 p44 0 299931.997066
Rn44 n43 rn44 0.0126107020997
Ln44 rn44 n44 3.93283691458e-10
Cgn44 n44 0 7.14662302799e-14
Rgn44 n44 0 299931.997066
K44 Lp44 Ln44 0.291475863148
Cm44 p44 n44 1.59780115097e-14
Rp45 p44 rp45 0.0126107020997
Lp45 rp45 p45 3.93283691458e-10
Cgp45 p45 0 7.14662302799e-14
Rgp45 p45 0 299931.997066
Rn45 n44 rn45 0.0126107020997
Ln45 rn45 n45 3.93283691458e-10
Cgn45 n45 0 7.14662302799e-14
Rgn45 n45 0 299931.997066
K45 Lp45 Ln45 0.291475863148
Cm45 p45 n45 1.59780115097e-14
Rp46 p45 rp46 0.0126107020997
Lp46 rp46 p46 3.93283691458e-10
Cgp46 p46 0 7.14662302799e-14
Rgp46 p46 0 299931.997066
Rn46 n45 rn46 0.0126107020997
Ln46 rn46 n46 3.93283691458e-10
Cgn46 n46 0 7.14662302799e-14
Rgn46 n46 0 299931.997066
K46 Lp46 Ln46 0.291475863148
Cm46 p46 n46 1.59780115097e-14
Rp47 p46 rp47 0.0126107020997
Lp47 rp47 p47 3.93283691458e-10
Cgp47 p47 0 7.14662302799e-14
Rgp47 p47 0 299931.997066
Rn47 n46 rn47 0.0126107020997
Ln47 rn47 n47 3.93283691458e-10
Cgn47 n47 0 7.14662302799e-14
Rgn47 n47 0 299931.997066
K47 Lp47 Ln47 0.291475863148
Cm47 p47 n47 1.59780115097e-14
Rp48 p47 rp48 0.0126107020997
Lp48 rp48 p48 3.93283691458e-10
Cgp48 p48 0 7.14662302799e-14
Rgp48 p48 0 299931.997066
Rn48 n47 rn48 0.0126107020997
Ln48 rn48 n48 3.93283691458e-10
Cgn48 n48 0 7.14662302799e-14
Rgn48 n48 0 299931.997066
K48 Lp48 Ln48 0.291475863148
Cm48 p48 n48 1.59780115097e-14
Rp49 p48 rp49 0.0126107020997
Lp49 rp49 p49 3.93283691458e-10
Cgp49 p49 0 7.14662302799e-14
Rgp49 p49 0 299931.997066
Rn49 n48 rn49 0.0126107020997
Ln49 rn49 n49 3.93283691458e-10
Cgn49 n49 0 7.14662302799e-14
Rgn49 n49 0 299931.997066
K49 Lp49 Ln49 0.291475863148
Cm49 p49 n49 1.59780115097e-14
Rp50 p49 rp50 0.0126107020997
Lp50 rp50 p50 3.93283691458e-10
Cgp50 p50 0 7.14662302799e-14
Rgp50 p50 0 299931.997066
Rn50 n49 rn50 0.0126107020997
Ln50 rn50 n50 3.93283691458e-10
Cgn50 n50 0 7.14662302799e-14
Rgn50 n50 0 299931.997066
K50 Lp50 Ln50 0.291475863148
Cm50 p50 n50 1.59780115097e-14
Rp51 p50 rp51 0.0126107020997
Lp51 rp51 p51 3.93283691458e-10
Cgp51 p51 0 7.14662302799e-14
Rgp51 p51 0 299931.997066
Rn51 n50 rn51 0.0126107020997
Ln51 rn51 n51 3.93283691458e-10
Cgn51 n51 0 7.14662302799e-14
Rgn51 n51 0 299931.997066
K51 Lp51 Ln51 0.291475863148
Cm51 p51 n51 1.59780115097e-14
Rp52 p51 rp52 0.0126107020997
Lp52 rp52 p52 3.93283691458e-10
Cgp52 p52 0 7.14662302799e-14
Rgp52 p52 0 299931.997066
Rn52 n51 rn52 0.0126107020997
Ln52 rn52 n52 3.93283691458e-10
Cgn52 n52 0 7.14662302799e-14
Rgn52 n52 0 299931.997066
K52 Lp52 Ln52 0.291475863148
Cm52 p52 n52 1.59780115097e-14
Rp53 p52 rp53 0.0126107020997
Lp53 rp53 p53 3.93283691458e-10
Cgp53 p53 0 7.14662302799e-14
Rgp53 p53 0 299931.997066
Rn53 n52 rn53 0.0126107020997
Ln53 rn53 n53 3.93283691458e-10
Cgn53 n53 0 7.14662302799e-14
Rgn53 n53 0 299931.997066
K53 Lp53 Ln53 0.291475863148
Cm53 p53 n53 1.59780115097e-14
Rp54 p53 rp54 0.0126107020997
Lp54 rp54 p54 3.93283691458e-10
Cgp54 p54 0 7.14662302799e-14
Rgp54 p54 0 299931.997066
Rn54 n53 rn54 0.0126107020997
Ln54 rn54 n54 3.93283691458e-10
Cgn54 n54 0 7.14662302799e-14
Rgn54 n54 0 299931.997066
K54 Lp54 Ln54 0.291475863148
Cm54 p54 n54 1.59780115097e-14
Rp55 p54 rp55 0.0126107020997
Lp55 rp55 p55 3.93283691458e-10
Cgp55 p55 0 7.14662302799e-14
Rgp55 p55 0 299931.997066
Rn55 n54 rn55 0.0126107020997
Ln55 rn55 n55 3.93283691458e-10
Cgn55 n55 0 7.14662302799e-14
Rgn55 n55 0 299931.997066
K55 Lp55 Ln55 0.291475863148
Cm55 p55 n55 1.59780115097e-14
Rp56 p55 rp56 0.0126107020997
Lp56 rp56 p56 3.93283691458e-10
Cgp56 p56 0 7.14662302799e-14
Rgp56 p56 0 299931.997066
Rn56 n55 rn56 0.0126107020997
Ln56 rn56 n56 3.93283691458e-10
Cgn56 n56 0 7.14662302799e-14
Rgn56 n56 0 299931.997066
K56 Lp56 Ln56 0.291475863148
Cm56 p56 n56 1.59780115097e-14
Rp57 p56 rp57 0.0126107020997
Lp57 rp57 p57 3.93283691458e-10
Cgp57 p57 0 7.14662302799e-14
Rgp57 p57 0 299931.997066
Rn57 n56 rn57 0.0126107020997
Ln57 rn57 n57 3.93283691458e-10
Cgn57 n57 0 7.14662302799e-14
Rgn57 n57 0 299931.997066
K57 Lp57 Ln57 0.291475863148
Cm57 p57 n57 1.59780115097e-14
Rp58 p57 rp58 0.0114834917607
Lp58 rp58 p58 3.58514488742e-10
Cgp58 p58 0 6.53852018023e-14
Rgp58 p58 0 327826.611829
Rn58 n57 rn58 0.0114834917607
Ln58 rn58 n58 3.58514488742e-10
Cgn58 n58 0 6.53852018023e-14
Rgn58 n58 0 327826.611829
K58 Lp58 Ln58 0.283888055317
Cm58 p58 n58 1.39826269982e-14
Rp59 p58 rp59 0.0132800014544
Lp59 rp59 p59 4.14438210493e-10
Cgp59 p59 0 7.5478775957e-14
Rgp59 p59 0 283987.238781
Rn59 n58 rn59 0.0132800014544
Ln59 rn59 n59 4.14438210493e-10
Cgn59 n59 0 7.5478775957e-14
Rgn59 n59 0 283987.238781
K59 Lp59 Ln59 0.286772249125
Cm59 p59 n59 1.64175147695e-14
Rp60 p59 rp60 0.0119808964031
Lp60 rp60 p60 3.73724619362e-10
Cgp60 p60 0 6.79686996831e-14
Rgp60 p60 0 315365.885629
Rn60 n59 rn60 0.0119808964031
Ln60 rn60 n60 3.73724619362e-10
Cgn60 n60 0 6.79686996831e-14
Rgn60 n60 0 315365.885629
K60 Lp60 Ln60 0.289774748097
Cm60 p60 n60 1.50479328913e-14
Rp61 p60 rp61 0.0127022954631
Lp61 rp61 p61 4.02034104709e-10
Cgp61 p61 0 7.94188416811e-14
Rgp61 p61 0 269898.285053
Rn61 n60 rn61 0.0127022954631
Ln61 rn61 n61 4.02034104709e-10
Cgn61 n61 0 7.94188416811e-14
Rgn61 n61 0 269898.285053
K61 Lp61 Ln61 0.131034084565
Cm61 p61 n61 5.12643053229e-15
Rp62 p61 rp62 0.0127022954631
Lp62 rp62 p62 4.03754978724e-10
Cgp62 p62 0 8.34866620281e-14
Rgp62 p62 0 256747.708555
Rn62 n61 rn62 0.0127022954631
Ln62 rn62 n62 4.03754978724e-10
Cgn62 n62 0 8.34866620281e-14
Rgn62 n62 0 256747.708555
K62 Lp62 Ln62 0.0316294332138
Cm62 p62 n62 6.28045185105e-16
Lcapp p62 capp 7e-10
Cacp capp acp 100n
Lcapn n62 capn 7e-10
Cacn capn acn 100n
Rp63 acp rp63 0.0127022954631
Lp63 rp63 p63 4.03754978724e-10
Cgp63 p63 0 8.34866620281e-14
Rgp63 p63 0 256747.708555
Rn63 acn rn63 0.0127022954631
Ln63 rn63 n63 4.03754978724e-10
Cgn63 n63 0 8.34866620281e-14
Rgn63 n63 0 256747.708555
K63 Lp63 Ln63 0.0316294332138
Cm63 p63 n63 6.28045185105e-16
Rp64 p63 rp64 0.0127022954631
Lp64 rp64 p64 4.02035318108e-10
Cgp64 p64 0 7.94200093639e-14
Rgp64 p64 0 269894.316839
Rn64 n63 rn64 0.0127022954631
Ln64 rn64 n64 4.02035318108e-10
Cgn64 n64 0 7.94200093639e-14
Rgn64 n64 0 269894.316839
K64 Lp64 Ln64 0.131013028797
Cm64 p64 n64 5.1249720094e-15
Rp65 p64 rp65 0.0125306257145
Lp65 rp65 p65 3.90765791155e-10
Cgp65 p65 0 7.09974280553e-14
Rgp65 p65 0 301912.474265
Rn65 n64 rn65 0.0125306257145
Ln65 rn65 n65 3.90765791155e-10
Cgn65 n65 0 7.09974280553e-14
Rgn65 n65 0 301912.474265
K65 Lp65 Ln65 0.29181809119
Cm65 p65 n65 1.5904927218e-14
Rp66 p65 rp66 0.0128995610877
Lp66 rp66 p66 4.02271254205e-10
Cgp66 p66 0 7.30879769967e-14
Rgp66 p66 0 293276.815852
Rn66 n65 rn66 0.0128995610877
Ln66 rn66 n66 4.02271254205e-10
Cgn66 n66 0 7.30879769967e-14
Rgn66 n66 0 293276.815852
K66 Lp66 Ln66 0.29181380363
Cm66 p66 n66 1.63728450706e-14
Rp67 p66 rp67 0.0116096049789
Lp67 rp67 p67 3.62044128784e-10
Cgp67 p67 0 6.5779179297e-14
Rgp67 p67 0 325863.128724
Rn67 n66 rn67 0.0116096049789
Ln67 rn67 n67 3.62044128784e-10
Cgn67 n67 0 6.5779179297e-14
Rgn67 n67 0 325863.128724
K67 Lp67 Ln67 0.29181380363
Cm67 p67 n67 1.47355605636e-14
Rp68 p67 rp68 0.0129069270096
Lp68 rp68 p68 4.02899748219e-10
Cgp68 p68 0 7.34492659589e-14
Rgp68 p68 0 291834.219046
Rn68 n67 rn68 0.0129069270096
Ln68 rn68 n68 4.02899748219e-10
Cgn68 n68 0 7.34492659589e-14
Rgn68 n68 0 291834.219046
K68 Lp68 Ln68 0.28478144664
Cm68 p68 n68 1.57910376098e-14
Rp69 p68 rp69 0.0129524468354
Lp69 rp69 p69 4.04322271942e-10
Cgp69 p69 0 7.369823485e-14
Rgp69 p69 0 290848.338692
Rn69 n68 rn69 0.0129524468354
Ln69 rn69 n69 4.04322271942e-10
Cgn69 n69 0 7.369823485e-14
Rgn69 n69 0 290848.338692
K69 Lp69 Ln69 0.284996321794
Cm69 p69 n69 1.58625342958e-14
Rp70 p69 rp70 0.0116135778612
Lp70 rp70 p70 3.66339177842e-10
Cgp70 p70 0 6.98635915962e-14
Rgp70 p70 0 306812.299238
Rn70 n69 rn70 0.0116135778612
Ln70 rn70 n70 3.66339177842e-10
Cgn70 n70 0 6.98635915962e-14
Rgn70 n70 0 306812.299238
K70 Lp70 Ln70 0.19771789455
Cm70 p70 n70 8.19581360197e-15
Rp71 p70 rp71 0.0135479496489
Lp71 rp71 p71 4.28967926651e-10
Cgp71 p71 0 8.38047570348e-14
Rgp71 p71 0 255773.179579
Rn71 n70 rn71 0.0135479496489
Ln71 rn71 n71 4.28967926651e-10
Cgn71 n71 0 8.38047570348e-14
Rgn71 n71 0 255773.179579
K71 Lp71 Ln71 0.154790379485
Cm71 p71 n71 6.52600360538e-15
Rp72 p71 rp72 0.0116135778612
Lp72 rp72 p72 3.66646255119e-10
Cgp72 p72 0 7.02520186903e-14
Rgp72 p72 0 305115.917951
Rn72 n71 rn72 0.0116135778612
Ln72 rn72 n72 3.66646255119e-10
Cgn72 n72 0 7.02520186903e-14
Rgn72 n72 0 305115.917951
K72 Lp72 Ln72 0.189177478736
Cm72 p72 n72 7.65915584744e-15
Rp73 p72 rp73 0.012749047376
Lp73 rp73 p73 3.98151431527e-10
Cgp73 p73 0 7.2708765614e-14
Rgp73 p73 0 294806.396308
Rn73 n72 rn73 0.012749047376
Ln73 rn73 n73 3.98151431527e-10
Cgn73 n73 0 7.2708765614e-14
Rgn73 n73 0 294806.396308
K73 Lp73 Ln73 0.28129304071
Cm73 p73 n73 1.53132242499e-14
Rp74 p73 rp74 0.0126457620258
Lp74 rp74 p74 3.94208164696e-10
Cgp74 p74 0 7.15419159293e-14
Rgp74 p74 0 299614.6929
Rn74 n73 rn74 0.0126457620258
Ln74 rn74 n74 3.94208164696e-10
Cgn74 n74 0 7.15419159293e-14
Rgn74 n74 0 299614.6929
K74 Lp74 Ln74 0.294261034376
Cm74 p74 n74 1.62559276535e-14
Rp75 p74 rp75 0.0127001223594
Lp75 rp75 p75 4.01461307843e-10
Cgp75 p75 0 7.82705417186e-14
Rgp75 p75 0 273857.93812
Rn75 n74 rn75 0.0127001223594
Ln75 rn75 n75 4.01461307843e-10
Cgn75 n75 0 7.82705417186e-14
Rgn75 n75 0 273857.93812
K75 Lp75 Ln75 0.156999488075
Cm75 p75 n75 6.52096625328e-15
Rp76 p75 rp76 0.0129665615061
Lp76 rp76 p76 4.36079683666e-10
Cgp76 p76 0 7.90077389331e-14
Rgp76 p76 0 271302.65288
Rn76 n75 rn76 0.0129665615061
Ln76 rn76 n76 4.36079683666e-10
Cgn76 n76 0 7.90077389331e-14
Rgn76 n76 0 271302.65288
K76 Lp76 Ln76 0.0520353816067
Cm76 p76 n76 1.15994451374e-15
Rp77 p76 rp77 0.0122294275636
Lp77 rp77 p77 4.59799442987e-10
Cgp77 p77 0 6.52936278951e-14
Rgp77 p77 0 328286.386614
Rn77 n76 rn77 0.0122294275636
Ln77 rn77 n77 4.59799442987e-10
Cgn77 n77 0 6.52936278951e-14
Rgn77 n77 0 328286.386614
K77 Lp77 Ln77 0.0346813401655
Cm77 p77 n77 5.59084117694e-16
LbiasP p63 brP 3.77992786471e-09
CbiP p63 0 2.6158670344e-13
CboP brP 0 2.6158670344e-13
RbiasP brP 0 499
LbiasN n63 brN 3.59047298049e-09
CbiN n63 0 2.48475638788e-13
CboN brN 0 2.48475638788e-13
RbiasN brN 0 499
Cesdp p70 0 7e-13
Cesdn n70 0 7e-13
Rp78 p77 rp78 0.0230398976868
Lp78 rp78 p78 4.83460214636e-10
Cgp78 p78 0 1.93384085855e-13
Rgp78 p78 0 110841.639714
Rn78 n77 rn78 0.0230398976868
Ln78 rn78 n78 4.83460214636e-10
Cgn78 n78 0 1.93384085855e-13
Rgn78 n78 0 110841.639714
Rp79 p78 rp79 0.0230398976868
Lp79 rp79 p79 4.83460214636e-10
Cgp79 p79 0 1.93384085855e-13
Rgp79 p79 0 110841.639714
Rn79 n78 rn79 0.0230398976868
Ln79 rn79 n79 4.83460214636e-10
Cgn79 n79 0 1.93384085855e-13
Rgn79 n79 0 110841.639714
Rp80 p79 rp80 0.0230398976868
Lp80 rp80 p80 4.83460214636e-10
Cgp80 p80 0 1.93384085855e-13
Rgp80 p80 0 110841.639714
Rn80 n79 rn80 0.0230398976868
Ln80 rn80 n80 4.83460214636e-10
Cgn80 n80 0 1.93384085855e-13
Rgn80 n80 0 110841.639714
Rp81 p80 rp81 0.0230398976868
Lp81 rp81 p81 4.83460214636e-10
Cgp81 p81 0 1.93384085855e-13
Rgp81 p81 0 110841.639714
Rn81 n80 rn81 0.0230398976868
Ln81 rn81 n81 4.83460214636e-10
Cgn81 n81 0 1.93384085855e-13
Rgn81 n81 0 110841.639714
Rp82 p81 rp82 0.0230398976868
Lp82 rp82 p82 4.83460214636e-10
Cgp82 p82 0 1.93384085855e-13
Rgp82 p82 0 110841.639714
Rn82 n81 rn82 0.0230398976868
Ln82 rn82 n82 4.83460214636e-10
Cgn82 n82 0 1.93384085855e-13
Rgn82 n82 0 110841.639714
Rp83 p82 rp83 0.0230398976868
Lp83 rp83 p83 4.83460214636e-10
Cgp83 p83 0 1.93384085855e-13
Rgp83 p83 0 110841.639714
Rn83 n82 rn83 0.0230398976868
Ln83 rn83 n83 4.83460214636e-10
Cgn83 n83 0 1.93384085855e-13
Rgn83 n83 0 110841.639714
Rtermp p83 vterm 50
Crxp p83 0 7e-13
Rtermn n83 vterm 50
Crxn n83 0 7e-13
Brxp rx_p 0 V={V(p83)}
Brxn rx_n 0 V={V(n83)}
Bdiff rx_diff 0 V={V(rx_p)-V(rx_n)}
Bsrcdiff src_diff 0 V={V(srcp)-V(srcn)}
.options reltol=.002 abstol=1p vntol=1u method=gear itl4=150
.save v(rx_p) v(rx_n) v(rx_diff) v(src_diff)
.tran 1.3468013468e-11 1.73737373737e-07 0 8.97867564534e-12
.end
